.subckt c1_003_chain vss vdd in out
mn0 out in vss vss sky130_fd_pr__nfet_01v8 w=1.68e-6 l=150e-9 nf=8
mp0 out in vdd vdd pmos_rvt w=21.0e-7 l=150e-9 nf=2
.ends c1_003_chain
