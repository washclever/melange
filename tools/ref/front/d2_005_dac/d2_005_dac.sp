.subckt d2_005_dac vdd vss bias out s0 s1 s2 s3 s4 s5 s6 s7 s8 s9 s10 s11
M1 bias bias vss vss nmos_lvt w=2100e-9 l=150e-9 nf=6
M2 d0 bias vss vss nmos_lvt w=2100e-9 l=150e-9 nf=6
M3 d1 bias vss vss nmos_lvt w=2100e-9 l=150e-9 nf=6
M4 d2 bias vss vss nmos_lvt w=2100e-9 l=150e-9 nf=6
M5 d3 bias vss vss nmos_lvt w=2100e-9 l=150e-9 nf=6
M6 d4 bias vss vss nmos_lvt w=2100e-9 l=150e-9 nf=6
M7 d5 bias vss vss nmos_lvt w=2100e-9 l=150e-9 nf=6
M8 d6 bias vss vss nmos_lvt w=2100e-9 l=150e-9 nf=6
M9 d7 bias vss vss nmos_lvt w=2100e-9 l=150e-9 nf=6
M10 d8 bias vss vss nmos_lvt w=2100e-9 l=150e-9 nf=6
M11 d9 bias vss vss nmos_lvt w=2100e-9 l=150e-9 nf=6
M12 d10 bias vss vss nmos_lvt w=2100e-9 l=150e-9 nf=6
M13 d11 bias vss vss nmos_lvt w=2100e-9 l=150e-9 nf=6
M14 d0 s0 out vss nmos_lvt w=1680e-9 l=150e-9 nf=12
M15 d1 s1 out vss nmos_lvt w=630e-9 l=150e-9 nf=6
M16 d2 s2 out vss nmos_lvt w=1050e-9 l=150e-9 nf=12 m=1
M17 d3 s3 out vss nmos_lvt w=1260e-9 l=150e-9 nf=10
M18 d4 s4 out vss nmos_lvt w=630e-9 l=150e-9 nf=10 m=2
M19 d5 s5 out vss nmos_lvt w=1050e-9 l=150e-9 nf=4
M20 d6 s6 out vss nmos_lvt w=420e-9 l=150e-9 nf=8
M21 d7 s7 out vss nmos_lvt w=420e-9 l=150e-9 nf=2
M22 d8 s8 out vss nmos_lvt w=840e-9 l=150e-9 nf=4
M23 d9 s9 out vss nmos_lvt w=630e-9 l=150e-9 nf=2
M24 d10 s10 out vss nmos_lvt w=420e-9 l=150e-9 nf=2
M25 d11 s11 out vss nmos_lvt w=420e-9 l=150e-9 nf=6
.ends d2_005_dac
